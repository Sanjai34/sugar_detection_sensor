# Ansys Electronics Desktop project, version 2023.2
materials:
  vacuum: permittivity=1
  Rogers RO4003 (tm): permittivity=3.55 dielectric_loss_tangent=0.0027
  air: permittivity=1.0006 permeability=1.0000004 mass_density=1.1614
  glass: permittivity=5.5 mass_density=2500
  BLOOD_300MG: permittivity=58.8 dielectric_loss_tangent=0.507
  BONE: permittivity=20
  FAT: permittivity=5.5
  skin: permittivity=41.5 conductivity=0.86 dielectric_loss_tangent=0.43
  BLOOD_0MG: permittivity=59.7 dielectric_loss_tangent=1.143
  BLOOD_50MG: permittivity=57.81 dielectric_loss_tangent=0.867
  BLOOD_100MG: permittivity=59.03 dielectric_loss_tangent=0.619
  BLOOD_150MG: permittivity=58.67 dielectric_loss_tangent=0.556
  BLOOD_200MG: permittivity=58.84 dielectric_loss_tangent=0.532
  BLOOD_250MG: permittivity=58.86 dielectric_loss_tangent=0.516

design HFSSDesign1 (HFSS, HFSS Modal Network, model units mm)
variables:
  a = 12mm
  b = 11mm
geometry:
  Box1 [Rogers RO4003 (tm)] = box(corner=((-20/2) mm, (-66/2) mm, 0mm), size=(20mm, 66mm, 0.8mm))
  microstripline = rectangle(corner=((-1.5/2) mm, -33mm, 0mm), x_size=1.5mm, y_size=66mm)
  PATCH = rectangle(corner=(-10mm, -33mm, 0.8mm), x_size=20mm, y_size=66mm)
  hex11 = circle(normal=Z, centre=(-6mm, 0mm, 0.8mm), radius=(7.6/2) mm, segments=8)
  Circle5 = circle(normal=Z, centre=(-6mm, 0mm, 0.8mm), radius=3.6mm, segments=8)
  hex11.subtract(Circle5)
  Rectangle8 = rectangle(corner=(-9.9mm, (-0.1/2) mm, 0.8mm), x_size=0.45mm, y_size=0.1mm)
  hex11.subtract(Rectangle8)
  hex12 = circle(normal=Z, centre=(-6mm, 0mm, 0.8mm), radius=3.4mm, segments=8)
  Circle7 = circle(normal=Z, centre=(-6mm, 0mm, 0.8mm), radius=3.2mm, segments=8)
  hex12.subtract(Circle7)
  Rectangle9 = rectangle(corner=(-2.55mm, (-0.1/2) mm, 0.8mm), x_size=-0.8mm, y_size=0.1mm)
  hex12.subtract(Rectangle9)
  hex21 = circle(normal=Z, centre=(0mm, -6.3mm, 0.8mm), radius=(7.6/2) mm, segments=8)
  Circle8 = circle(normal=Z, centre=(0mm, -6.3mm, 0.8mm), radius=3.6mm, segments=8)
  hex21.subtract(Circle8)
  Rectangle10 = rectangle(corner=(-4mm, -6.35mm, 0.8mm), x_size=0.8mm, y_size=0.1mm)
  hex21.subtract(Rectangle10)
  hex22 = circle(normal=Z, centre=(0mm, -6.3mm, 0.8mm), radius=3.4mm, segments=8)
  Circle12 = circle(normal=Z, centre=(0mm, -6.3mm, 0.8mm), radius=3.2mm, segments=8)
  hex22.subtract(Circle12)
  Rectangle11 = rectangle(corner=(3.45mm, -6.35mm, 0.8mm), x_size=-0.65mm, y_size=0.1mm)
  hex22.subtract(Rectangle11)
  hex31 = circle(normal=Z, centre=(6mm, 0mm, 0.8mm), radius=(7.6/2) mm, segments=8)
  Circle10 = circle(normal=Z, centre=(6mm, 0mm, 0.8mm), radius=3.6mm, segments=8)
  hex31.subtract(Circle10)
  Rectangle12 = rectangle(corner=(2.1mm, (-0.1/2) mm, 0.8mm), x_size=0.7mm, y_size=0.1mm)
  hex31.subtract(Rectangle12)
  hex32 = circle(normal=Z, centre=(6mm, 0mm, 0.8mm), radius=3.4mm, segments=8)
  Circle14 = circle(normal=Z, centre=(6mm, 0mm, 0.8mm), radius=3.2mm, segments=8)
  hex32.subtract(Circle14)
  Rectangle13 = rectangle(corner=(8.75mm, (-0.1/2) mm, 0.8mm), x_size=0.7mm, y_size=0.1mm)
  hex32.subtract(Rectangle13)
  hex41 = circle(normal=Z, centre=(0mm, 6.3mm, 0.8mm), radius=(7.6/2) mm, segments=8)
  Circle9 = circle(normal=Z, centre=(0mm, 6.3mm, 0.8mm), radius=3.6mm, segments=8)
  hex41.subtract(Circle9)
  Rectangle14 = rectangle(corner=(-3.9mm, 6.25mm, 0.8mm), x_size=0.7mm, y_size=0.1mm)
  hex41.subtract(Rectangle14)
  hex42 = circle(normal=Z, centre=(0mm, 6.3mm, 0.8mm), radius=3.4mm, segments=8)
  Circle16 = circle(normal=Z, centre=(0mm, 6.3mm, 0.8mm), radius=3.2mm, segments=8)
  hex42.subtract(Circle16)
  Rectangle15 = rectangle(corner=(2.75mm, 6.25mm, 0.8mm), x_size=0.7mm, y_size=0.1mm)
  hex42.subtract(Rectangle15)
  PATCH.subtract(hex11, hex12, hex21, hex22, hex31, hex32, hex41, hex42)
  Rectangle6 = rectangle(corner=((1.5/2) mm, 33mm, 0mm), z_size=0.8mm, x_size=-1.5mm)
  Rectangle7 = rectangle(corner=((1.5/2) mm, -33mm, 0mm), z_size=0.8mm, x_size=-1.5mm)
  rad [air] = box(corner=(-90mm, -60mm, -4mm), size=(125mm, 110mm, 250mm))
  coordinate_system RelativeCS1 = origin=(-0.75mm, 0mm, 0mm) x=(1mm, 0mm, 0mm) y=(0mm, 1mm, 0mm)
  Male_Hand_Right1 = component(Male_Hand_Right, 3D_Component_File_Path="<syslib>/3DComponents/HFSS/Human Body Exteriors/Male/Male_Hand_Right.a3dcomp")
  Hand_Right [humanaverage, oriented by WristCS] = part_of(Male_Hand_Right1) in RelativeCS1
  [Box1, microstripline, PATCH, Rectangle6, Rectangle7, rad].move(-80.640535mm, -206.34605mm, 765.7971mm)
  [Box1, rad, Rectangle6, Rectangle7, microstripline, PATCH].move(10mm, 0mm, 0mm)
  [Rectangle6, Rectangle7, microstripline, PATCH, rad, Box1].move(3.640535mm, 0.34605mm, 0.2029mm)
  [Box1, PATCH, microstripline, Rectangle7, Rectangle6].move(0mm, 0mm, -0.6mm)
  [Box1, Rectangle6, Rectangle7, microstripline, PATCH].move(-0.01285mm, -208.014mm, -0.1027mm)
  [Box1, microstripline, PATCH, Rectangle6, Rectangle7].move(-9.55mm, 206mm, 0mm)
  [Rectangle6, PATCH, microstripline, Rectangle7, Box1].move(10mm, 0mm, 0mm)
  [microstripline, PATCH, Rectangle7, Rectangle6, Box1].move(-10mm, 2.8421709e-14mm, 0.15mm)
  [PATCH, microstripline, Rectangle7, Rectangle6, Box1].move(10mm, 0mm, 0mm)
boundaries and excitations:
  PerfE1: Perfect E Objects=microstripline
  PerfE2: Perfect E Objects=PATCH
  Rad1: Radiation Objects=rad
  1: Lumped Port Objects=Rectangle6 LumpedPortType=Modal Modes{Mode1{IntLine{(-66.56285, -175.014, 765.4473) -> (-66.56285, -175.014, 766.2473)} CharImp=Zpi RenormImp=50ohm}} Impedance=50ohm
  2: Lumped Port Objects=Rectangle7 LumpedPortType=Modal Modes{Mode1{IntLine{(-66.56285, -241.014, 765.4473) -> (-66.56285, -241.014, 766.2473)} CharImp=Zpi RenormImp=50ohm}} Impedance=50ohm
setups:
  Setup1: HfssDriven Frequency=2.4GHz MaxDeltaS=0.02 MaximumPasses=6 MinimumPasses=1 MinimumConvergedPasses=1 PercentRefinement=30 BasisOrder=1 PortAccuracy=2 DrivenSolverType="Direct Solver"
    sweep Sweep: 1.2GHz to 1.9GHz, 401 points; Type=Interpolating InterpTolerance=0.5 InterpMaxSolns=250 InterpUsePortImped=false PassivityErrorTolerance=0.0001
source amplitudes:
  1:1, 2:1: 100mW 0deg
radiation setups:
  Infinite Sphere1: Infinite Sphere Theta=0deg..360deg step 10deg Phi=-180deg..180deg step 10deg
field plots:
  Average_SAR1: SAR Field on Setup1 : LastAdaptive at Freq=2.4GHz Phase=0deg
reports:
  S Parameter Plot 1: dB(S(1,1)), dB(S(1,1)), dB(S(1,1)), dB(S(1,1)), dB(S(1,1)), dB(S(1,1)), dB(S(1,1)) vs Freq; markers 0MG at 1.71GHz, 50MG at 1.71GHz, 100MG at 1.71GHz, 150MG at 1.71GHz, 200MG at 1.71GHz, 250MG at 1.71GHz, 300MG at 1.71GHz
  Gain Plot 1: dB(GainTotal) vs Theta on Setup1 : LastAdaptive, Infinite Sphere1 [Phi=0deg Freq=2.4GHz a=all]; dB(GainTotal) vs Theta
  Gain Plot 2: dB(GainTotal) vs Theta on Setup1 : LastAdaptive, Infinite Sphere1 [Phi=90deg Freq=2.4GHz]; dB(GainTotal) vs Theta
  S Parameter Plot 2: dB(S(2,1)) vs Freq on Setup1 : Sweep
  S Parameter Plot 3: dB(S(2,1)) vs Freq on Setup1 : Sweep
  S Parameter Plot 4: dB(S(2,1)) vs Freq on Setup1 : Sweep
  S Parameter Plot 5: dB(S(1,1)), dB(S(2,1)), dB(S(1,2)), dB(S(2,2)) vs Freq on Setup1 : Sweep
  S Parameter Plot 6: dB(S(1,1)) vs Freq on Setup1 : Sweep
  S Parameter Plot 7: dB(S(1,1)), dB(S(2,1)) vs Freq on Setup1 : Sweep
  S Parameter Plot 8: dB(S(1,1)), -ang_rad(S(1,1)) vs Freq on Setup1 : Sweep
  S Parameter Plot 9: dB(S(1,1)) vs Freq on Setup1 : Sweep

design HFSSDesign2 (HFSS, HFSS Modal Network, model units mm)
geometry:
  Box1 [Rogers RO4003 (tm)] = box(corner=((-7.8/2) mm, (-7.8/2) mm, 0mm), size=(7.8mm, 7.8mm, 0.8mm))
  patch = rectangle(corner=((-7.8/2) mm, (-7.8/2) mm, 0.8mm), x_size=7.8mm, y_size=7.8mm)
  hex11 = circle(normal=Z, centre=(0mm, 0mm, 0.8mm), radius=(7.6/2) mm, segments=8)
  Circle5 = circle(normal=Z, centre=(0mm, 0mm, 0.8mm), radius=3.6mm, segments=8)
  hex11.subtract(Circle5)
  hex12 = circle(normal=Z, centre=(0mm, 0mm, 0.8mm), radius=3.4mm, segments=8)
  Circle7 = circle(normal=Z, centre=(0mm, 0mm, 0.8mm), radius=3.2mm, segments=8)
  hex12.subtract(Circle7)
  Rectangle8 = rectangle(corner=(2.9mm, (-0.1/2) mm, 0.8mm), x_size=0.6mm, y_size=0.1mm)
  Rectangle9 = rectangle(corner=(-3.55mm, (-0.1/2) mm, 0.8mm), x_size=-0.8mm, y_size=0.1mm)
  hex11.subtract(Rectangle9)
  hex12.subtract(Rectangle8)
  patch.subtract(hex11, hex12)
  Region [vacuum] = region(percentage_offset: +X=0, -X=0, +Y=0, -Y=0, +Z=200, -Z=200)
boundaries and excitations:
  PerfE1: Perfect E Objects=patch
  PerfH1: Perfect H Faces=Region.face(+z, -z)
  PerfE2: Perfect E Faces=Region.face(+x, -x)
  1: Wave Port Faces=Region.face(+y) WavePortType=Modal NumModes=1 Modes{Mode1{IntLine{(3.9, 3.9, 0.4) -> (-3.9, 3.9, 0.4)} CharImp=Zpi}}
  2: Wave Port Faces=Region.face(-y) WavePortType=Modal NumModes=1 Modes{Mode1{IntLine{(3.9, -3.9, 0.4) -> (-3.9, -3.9, 0.4)} CharImp=Zpi}}
setups:
  Setup1: HfssDriven Frequency=1.7GHz MaxDeltaS=0.02 MaximumPasses=10 MinimumPasses=1 MinimumConvergedPasses=1 PercentRefinement=30 BasisOrder=1 PortAccuracy=2 DrivenSolverType="Direct Solver"
    sweep Sweep: 2.5GHz to 4.5GHz, 401 points; Type=Interpolating InterpTolerance=0.5 InterpMaxSolns=250 InterpUsePortImped=false PassivityErrorTolerance=0.0001
source amplitudes:
  1:1: 1W 0deg
  2:1: 0W 0deg
reports:
  S Parameter Plot 1: dB(S(1,1)), dB(S(2,1)) vs Freq on Setup1 : Sweep
  S Parameter Plot 2: ang_rad(S(1,1)), ang_rad(S(2,1)) vs Freq on Setup1 : Sweep
  S Parameter Plot 3: mag(S(1,1)), mag(S(2,1)) vs Freq on Setup1 : Sweep
  S Parameter Table 1: mag(S(1,1)) vs Freq on Setup1 : Sweep
  S Parameter Table 2: mag(S(1,1)), -ang_rad(S(1,1)) vs Freq on Setup1 : Sweep
  S Parameter Table 3: mag(S(2,1)), -ang_rad(S(2,1)) vs Freq on Setup1 : Sweep
  S Parameter Plot 4: mag(S(1,1)), mag(S(2,1)) vs Freq on Setup1 : Sweep
  S Parameter Table 4: dB(S(1,1)) vs Freq on Setup1 : Sweep
  S Parameter Table 5: dB(S(1,1)) vs Freq on Setup1 : Sweep
  S Parameter Table 6: dB(S(1,1)), -ang_rad(S(1,1)) vs Freq on Setup1 : Sweep
  S Parameter Table 7: dB(S(2,1)), -ang_rad(S(2,1)) vs Freq on Setup1 : Sweep
  S11: dB(S(1,1)), -ang_rad(S(1,1)) vs Freq on Setup1 : Sweep
  S21: dB(S(2,1)), -ang_rad(S(2,1)) vs Freq on Setup1 : Sweep
  S Parameter Plot 5: dB(S(1,1)), dB(S(2,1)) vs Freq on Setup1 : Sweep
  S Parameter Plot 6: mag(S(1,1)) vs Freq on Setup1 : Sweep
  S Parameter Plot 7: mag(S(1,1)), mag(S(2,1)) vs Freq on Setup1 : Sweep
  S Parameter Plot 8: dB(S(1,1)), dB(S(2,1)) vs Freq on Setup1 : Sweep
  S Parameter Plot 9: mag(S(1,1)), mag(S(2,1)) vs Freq on Setup1 : Sweep
  S Parameter Plot 10: ang_rad(S(1,1)), ang_rad(S(2,1)) vs Freq on Setup1 : Sweep
  S Parameter Plot 11: ang_rad(S(1,1)), -ang_rad(S(2,1)) vs Freq on Setup1 : Sweep
  S Parameter Plot 12: dB(S(1,1)), dB(S(2,1)) vs Freq on Setup1 : Sweep
  S Parameter Plot 13: dB(S(1,1)), dB(S(2,1)) vs Freq on Setup1 : Sweep
  S Parameter Plot 14: dB(S(1,1)), dB(S(2,1)) vs Freq on Setup1 : Sweep
  S Parameter Plot 15: ang_rad(S(1,1)), -ang_rad(S(2,1)) vs Freq on Setup1 : Sweep

design HFSSDesign3 (HFSS, HFSS Modal Network, model units mm)
geometry:
  Box1 [Rogers RO4003 (tm)] = box(corner=((-7.8/2) mm, (-7.8/2) mm, 0mm), size=(7.8mm, 7.8mm, 0.8mm))
  hex11 = circle(normal=Z, centre=(0mm, 0mm, 0.8mm), radius=(7.6/2) mm, segments=8)
  Circle5 = circle(normal=Z, centre=(0mm, 0mm, 0.8mm), radius=3.6mm, segments=8)
  hex11.subtract(Circle5)
  Rectangle9 = rectangle(corner=(-3.55mm, (-0.1/2) mm, 0.8mm), x_size=-0.8mm, y_size=0.1mm)
  hex11.subtract(Rectangle9)
  hex12 = circle(normal=Z, centre=(0mm, 0mm, 0.8mm), radius=3.4mm, segments=8)
  Circle7 = circle(normal=Z, centre=(0mm, 0mm, 0.8mm), radius=3.2mm, segments=8)
  hex12.subtract(Circle7)
  Rectangle8 = rectangle(corner=(2.9mm, (-0.1/2) mm, 0.8mm), x_size=0.6mm, y_size=0.1mm)
  hex12.subtract(Rectangle8)
boundaries and excitations:
  PerfE1: Perfect E Objects=[hex11, hex12]
